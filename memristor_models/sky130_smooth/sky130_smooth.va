// Copyright 2020 The SkyWater PDK Authors
//
// Licensed under the Apache License, Version 2.0 (the "License");
// you may not use this file except in compliance with the License.
// You may obtain a copy of the License at
//
//     https://www.apache.org/licenses/LICENSE-2.0
//
// Unless required by applicable law or agreed to in writing, software
// distributed under the License is distributed on an "AS IS" BASIS,
// WITHOUT WARRANTIES OR CONDITIONS OF ANY KIND, either express or implied.
// See the License for the specific language governing permissions and
// limitations under the License.
//
// SPDX-License-Identifier: Apache-2.0

`include "constants.vams"
`include "disciplines.vams"

module sky130_smooth_module(TE, BE, nFilament);
    inout TE; // top electrode
    inout BE; // bottom electrode
    inout nFilament; // filament state
    electrical TE, BE, nFilament, nT;

    // ==================================================
    // input parameters
    // --------------------------------------------------
    // physical area and thickness
    parameter real area_ox             = 0.1024e-12 from (0:inf);                         // area of TE/BE overlap [meters^2]
    parameter real Tox                 = 5.0     from (0:inf);                         // thickness of oxide between TE and BE [nano meters]
    parameter real Tfilament_max       = 4.9     from (0:inf);                         // maximum thickness of conductive filament (for minimum resistance) [nano meters]
    parameter real Tfilament_min       = 3.3     from (0:inf);                         // minimum thickness of conductive filament (for maximum resistance) [nano meters]
    // activation energy
    parameter real Eact_generation     = 1.501      from (0:inf);                         // activation energy for vacancy generation [eV]
    parameter real Eact_recombination  = 1.500      from (0:inf);                         // activation energy for vacancy recombination [eV]
    // calibration parameters: I-V
    parameter real I_k1                = 6.140e-5   from (0:inf);                         // current calibration parameter [Amps]
    parameter real Tfilament_ref       = 4.7249  from (0:inf);                         // filament thickness calibration parameter [nano meters]
    parameter real V_ref               = 0.430      from (0:inf);                         // voltage calibration parameter [Volts]
    // calibration parameters: filament growth
    parameter real velocity_k1         = 150        from (0:inf);                         // velocity calibration parameter [meters/second]
    parameter real gamma_k0            = 16.5       from (0:inf);                         // enhancement factor calibration parameter [unitless]
    parameter real gamma_k1            = -1.25      from (-inf:inf);                      // enhancement factor calibration parameter [unitless]
    // calibration parameters: temperature
    parameter real Temperature_0       = 300        from (0:inf);                         // intial temperature [degrees Kelvin]
    parameter real C_thermal           = 3.1825e-16 from (0:inf);                         // effective thermal capacitance [Joules/Kelvin]
    parameter real tau_thermal         = 0.23e-9    from (0:inf);                         // effective thermal time constant [seconds]
    // simulation control
    parameter real t_step              = 1.0e-6     from (0:inf);                         // maximum time step [seconds]
    parameter real smoothing = 1e-8 from (0:inf);                                         // smoothing for limit step
    parameter real Kclip = 200 from (0:inf);                                              // clip between max/min
    parameter real maxslope = 1e15 from (0:inf);

    // ==================================================

    // internal parameters
    real a0 = 0.25;           // atomic distance [nm]
    real Tfilament_current;      // current filament thickness [m]
    real Tfilament_dTdt;         // current filament thickness, derivative w.r.t. time [m/s]
    real gamma;                  // local enhancement factor
    real Temperature_current;    // current temperature
    real kT_over_q;              // e.g., 0.0259 at 300 degrees K [eV]
    real Fw1, Fw2;               // calculate limit step

    // transient simulation parameters
    real t_current;              // current time step [s]
    real t_previous;             // previous time step [s]
    real t_delta;                // difference between current vs. previous time step

    analog function real smoothstep;
        input x, smoothing;
        real  x, smoothing;
        begin
            smoothstep = 0.5*(x/sqrt(x*x + smoothing)+1);
        end
    endfunction // smoothstep

    analog function real safeexp;
        input x, maxslope;
        real x, maxslope, breakpoint;
        begin
            breakpoint = log(maxslope);
            safeexp = exp(x*(x <= breakpoint))*(x <= breakpoint) + (x>breakpoint)*(maxslope + maxslope*(x-breakpoint));
        end
    endfunction

    analog function real safesinh;
        input x, maxslope;
        real  x, maxslope;
        begin
            safesinh = 0.5*(safeexp(x, maxslope) - safeexp(-x, maxslope));
        end
    endfunction

    analog function real smoothabs;
        input x, smoothing;
        real x, smoothing;
        begin
            smoothabs = sqrt(x*x + smoothing) - sqrt(smoothing);
        end
    endfunction // smoothabs

    // core equations
    analog begin
        $bound_step(t_step); // bound maximum time step
        Tfilament_current = V(nFilament, BE);
        Temperature_current = V(nT, BE);
        gamma = gamma_k0 + gamma_k1 * pow((Tox - Tfilament_current), 3);
        kT_over_q = (`P_K * Temperature_current) / `P_Q;
        Tfilament_dTdt = velocity_k1 * (safeexp(-Eact_generation    / kT_over_q, maxslope) * safeexp( gamma * a0/Tox * V(TE,BE) / kT_over_q, maxslope) -
                                        safeexp(-Eact_recombination / kT_over_q, maxslope) * safeexp(-gamma * a0/Tox * V(TE,BE) / kT_over_q, maxslope));
        Fw1 = smoothstep(Tfilament_min-Tfilament_current, smoothing);
        Fw2 = smoothstep(Tfilament_current-Tfilament_max, smoothing);
        I(nFilament, BE) <+ Tfilament_dTdt + (safeexp(Kclip*(Tfilament_min-Tfilament_current),maxslope) - Tfilament_dTdt) * Fw1 + (-safeexp(Kclip*(Tfilament_current-Tfilament_max),maxslope) - Tfilament_dTdt) * Fw2;
        I(nFilament, BE) <+ ddt(-1.0e-9*Tfilament_current);
        I(TE,BE) <+ I_k1 * safeexp(-(Tox - Tfilament_current)/(Tox - Tfilament_ref),maxslope) * safesinh( V(TE,BE)/V_ref, maxslope);
        I(nT, BE) <+ smoothabs(V(TE,BE)*I(TE,BE), smoothing)/C_thermal + (Temperature_0-Temperature_current)/tau_thermal;
        I(nT, BE) <+ ddt(-Temperature_current);
    end
endmodule
