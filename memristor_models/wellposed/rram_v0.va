`include "constants.vams"
`include "disciplines.vams"

//definicion de macros
`define IPRcc(nam,def,uni,lwr,upr,des) (*units=uni, type="instance", desc=des*) parameter real nam=def from [lwr:upr];

//parametros de instancia

module rram_v0_va(t, b);
    inout t, b;
    electrical t, b, nGap;

    parameter real g0 = 0.2751 from (0:inf);  //Tox - Tfilament_ref = 5.0 - 4.7249 (Tox - filament thickness calibration parameter)[nano meters]
    parameter real V0 = 0.430 from (0:inf);   // voltage calibration parameter [Volts]
    parameter real I0 = 6.140e-5 from (0:inf); // current calibration parameter [Amps]
    parameter real maxGap = 1.7 from (0:inf); //Tox - Tfilament_min = 5.0 - 3.3 // minimum thickness of conductive filament (for maximum resistance) [nano meters]
    parameter real minGap = 0.1 from (0:inf); //Tox - Tfilament_max = 5.0 - 4.9 // maximum thickness of conductive filament (for minimum resistance) [nano meters]
    parameter real Vel0 = 150 from (0:inf);
    parameter real Beta0 = -1.25 from (-inf:inf);
    parameter real gamma0 = 16.5 from (0:inf);
    parameter real Ea = 1.500 from (0:inf);
    parameter real a0 = 0.25 from (0:inf);
    parameter real tox = 5.0 from (0:inf); //
    parameter real smoothing = 1e-8 from (0:inf);
    parameter real GMIN = 1e-12 from (0:inf);
    parameter real Kclip = 50 from (0:inf);
    // parameter real maxslope = 1e16 from (0:inf);
    parameter real maxslope = 1e18 from (0:inf);
    `IPRcc(gap_initial, 0.9, "V", minGap, maxGap, "Initial Gap distance between tip of the filament and bottom electrode, represented as a voltage between 0.1 and 1.7")

    real ddt_Gap, Gap, Gamma, Fw1, Fw2, clip_maxGap, clip_minGap;

    // analog function real smoothstep;
    //     input x, smoothing;
    //     real x, smoothing;
    //     begin
    //         if (x > 1) begin
    //             smoothstep = 1;
    //         end else if (x < 0) begin
    //             smoothstep = 0;
    //         end else begin
    //             smoothstep = x;
    //         end
    //     end
    // endfunction // soft_minmax

    analog function real smoothstep;
        input x, smoothing;
        real  x, smoothing;
        begin
            smoothstep = 0.5*(x/sqrt(x*x + smoothing)+1);
        end
    endfunction // smoothstep

    analog function real safeexp;
        input x, maxslope;
        real x, maxslope, breakpoint;
        begin
            breakpoint = log(maxslope);
            safeexp = exp(x*(x <= breakpoint))*(x <= breakpoint) + (x>breakpoint)*(maxslope + maxslope*(x-breakpoint));
        end
    endfunction

    analog function real safesinh;
        input x, maxslope;
        real  x, maxslope;
        begin
            safesinh = 0.5*(safeexp(x, maxslope) - safeexp(-x, maxslope));
        end
    endfunction

    analog begin
        // Set the initial gap voltage at the first timestep
        @(initial_step) begin
            V(nGap, b) <= gap_initial; // Set the initial gap value
            $strobe("Gap Inicial %f", gap_initial);
        end
        Gap = V(nGap, b);
        I(t,b) <+ I0 * safeexp(-(Gap)/g0,maxslope) * safesinh(V(t, b)/V0, maxslope) + GMIN*V(t, b);
        Gamma = gamma0 + Beta0 * pow(Gap, 3);
        ddt_Gap =  -Vel0 * safeexp(-Ea/$vt, maxslope)*safesinh(V(t, b)*Gamma*a0/(tox*$vt), maxslope);
        Fw1 = smoothstep(minGap-Gap, smoothing);
        Fw2 = smoothstep(Gap-maxGap, smoothing);
        clip_minGap = (safeexp(Kclip*(minGap-Gap), maxslope) - ddt_Gap) * Fw1;
        clip_maxGap = (-safeexp(Kclip*(Gap-maxGap), maxslope) - ddt_Gap) * Fw2;
        I(nGap, b) <+ ddt_Gap + clip_minGap + clip_maxGap;
        I(nGap, b) <+ ddt(-1e-9*Gap);

        // Gap = V(nGap, b);
        // I(t,b) <+ I0 * exp(-(Gap)/g0) * sinh(V(t, b)/V0) + GMIN*V(t, b);
        // Gamma = gamma0 + Beta0 * pow(Gap, 3);
        // ddt_Gap =  -Vel0 * exp(-Ea/$vt)*sinh(V(t, b)*Gamma*a0/(tox*$vt));
        // Fw1 = smoothstep(minGap-Gap, smoothing);
        // Fw2 = smoothstep(Gap-maxGap, smoothing);
        // clip_minGap = (exp(Kclip*(minGap-Gap)) - ddt_Gap) * Fw1;
        // clip_maxGap = (-exp(Kclip*(Gap-maxGap)) - ddt_Gap) * Fw2;
        // I(nGap, b) <+ ddt_Gap + clip_minGap + clip_maxGap;
        // I(nGap, b) <+ ddt(-1e-9*Gap);
    end
endmodule
