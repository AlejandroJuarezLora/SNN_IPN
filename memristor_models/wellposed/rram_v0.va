`include "constants.vams"
`include "disciplines.vams"

module rram_v0_va(t, b);
    inout t, b;
    electrical t, b, ns;
    parameter real g0 = 0.271 from (0:inf);  //Tox - Tfilament_ref = 5.0 - 4.7249 (Tox - filament thickness calibration parameter)[nano meters]
    parameter real V0 = 0.430 from (0:inf);   // voltage calibration parameter [Volts]
    parameter real I0 = 6.140e-5 from (0:inf); // current calibration parameter [Amps]
    parameter real maxGap = 1.7 from (0:inf); //Tox - Tfilament_min = 5.0 - 3.3 // minimum thickness of conductive filament (for maximum resistance) [nano meters]
    parameter real minGap = 0.2 from (0:inf); //Tox - Tfilament_max = 5.0 - 4.9 // maximum thickness of conductive filament (for minimum resistance) [nano meters]
    parameter real Vel0 = 150 from (0:inf);
    parameter real Beta0 = -1.25 from (-inf:inf);
    parameter real gamma0 = 16.5 from (0:inf);
    parameter real Ea = 1.5 from (0:inf);
    parameter real a0 = 0.25 from (0:inf);
    parameter real tox = 5.0 from (0:inf);
    parameter real maxslope = 1e15 from (0:inf);
    parameter real smoothing = 1e-8 from (0:inf);
    parameter real GMIN = 1e-12 from (0:inf);
    parameter real Kclip = 50 from (0:inf);

    real s, f1, f2, Gap, Gamma, Fw1, Fw2, clip_maxGap, clip_minGap;

    analog function real dsmoothclip;
        input x, smoothing;
        real  x, smoothing;
        begin
            dsmoothclip = 0.5 * (x/sqrt(x*x + smoothing)) + 0.5;
        end
    endfunction // dsmoothclip

    analog function real smoothstep;
        input x, smoothing;
        real  x, smoothing;
        begin
            smoothstep = dsmoothclip(x, smoothing);
        end
    endfunction // smoothstep

//   analog function real smoothstep;
//       input x, smoothing;
//       real  x, smoothing;
//       begin
//           smoothstep = 0.5*(x/sqrt(x*x + smoothing)+1);
//       end
//   endfunction // smoothstep

  analog function real safeexp;
      input x, maxslope;
      real x, maxslope, breakpoint;
      begin
          breakpoint = log(maxslope);
          safeexp = exp(x*(x <= breakpoint))*(x <= breakpoint) + (x>breakpoint)*(maxslope + maxslope*(x-breakpoint));
      end
  endfunction

  analog function real safesinh;
      input x, maxslope;
      real  x, maxslope;
      begin
          safesinh = 0.5*(safeexp(x, maxslope) - safeexp(-x, maxslope));
      end
  endfunction

  analog begin
    s = V(ns, b);
    Gap = s*minGap + (1-s)*maxGap;
    f1 = I0 * safeexp(-(Gap)/g0, maxslope) * safesinh(V(t, b)/V0,maxslope);
    I(t,b) <+ f1 + GMIN*V(t, b);
    Gamma = gamma0 - Beta0 * pow(Gap, 3);
    f2 = (maxGap - minGap) * Vel0 * safeexp(-Ea/$vt, maxslope)*safesinh(V(t, b)*Gamma*a0/tox/$vt, maxslope);
    Fw1 = smoothstep(0-s, smoothing);
    Fw2 = smoothstep(s-1, smoothing);
    clip_minGap = (safeexp(Kclip*(0-s), maxslope) - f2) * Fw1;
    clip_maxGap = (-safeexp(Kclip*(s-1),maxslope) - f2) * Fw2;
    I(ns, b) <+ f2 + clip_minGap + clip_maxGap;
    I(ns, b) <+ ddt(-1e-9*s);
  end
endmodule
